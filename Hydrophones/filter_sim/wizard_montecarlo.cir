* Wizard design: Monte Carlo 1% R / 1% C
.param tolR=0.01 tolC=0.01
.step param run 1 100 1
V1 in vref AC 1
Vref vref 0 DC 1.65
Vdd vdd 0 DC 3.3
.subckt MFBR in out vref vdd params: R1=1k R2=1k R3=1G C=1n
R1 in n1 {mc(R1,tolR)}
R3 n1 vref {mc(R3,tolR)}
Ca n1 out {mc(C,tolC)}
Cb n1 inv {mc(C,tolC)}
R2 inv out {mc(R2,tolR)}
XU vref inv vdd 0 out AD8608
.ends
XW1 in w1 vref vdd MFBR R1=10.9k R3=1.74k R2=67.8k C=360p
XW2 w1 w2 vref vdd MFBR R1=11.1k R3=1.78k R2=69.6k C=750p
XW3 w2 w3 vref vdd MFBR R1=4.39k R3=39.2k R2=27.4k C=430p
XW4 w3 wiz vref vdd MFBR R1=4.29k R3=38.3k R2=26.8k C=620p
.lib ADI.lib
.ac list 25k 30k 35k 40k
.options meascplxfmt=cartesian
.meas AC c_new25 FIND V(wiz) AT 25k
.meas AC c_new30 FIND V(wiz) AT 30k
.meas AC c_new40 FIND V(wiz) AT 40k
.meas AC c_old25 FIND V(wiz) AT 25k
.meas AC c_old30 FIND V(wiz) AT 30k
.meas AC c_old40 FIND V(wiz) AT 40k
.end
