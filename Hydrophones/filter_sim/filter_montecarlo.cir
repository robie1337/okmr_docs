* Monte Carlo: channel-to-channel spread, 1% R / 5% C, GBW 10 MHz (AD8608-class)
.param GBW=10Meg tolR=0.01 tolC=0.05
.step param run 1 100 1
V1 in vref AC 1
Vref vref 0 DC 1.65
Vdd vdd 0 DC 3.3
.subckt MFB in out vref vdd params: R1=1k R2=1k R3=1G C=1n
R1 in n1 {mc(R1,tolR)}
R3 n1 vref {mc(R3,tolR)}
Ca n1 out {mc(C,tolC)}
Cb n1 inv {mc(C,tolC)}
R2 inv out {mc(R2,tolR)}
XU vref inv vdd 0 out level2 Avol=1Meg GBW={GBW} Slew=1Meg Ilimit=25m Rail=0 Vos=0 En=0 Enk=0 In=0 Ink=0 Rin=500Meg
.ends
XA in o1 vref vdd MFB R1=4.7k R3=10k R2=12k C=1n
XB o1 o2 vref vdd MFB R1=2.2k R3=680 R2=12k C=1n
XC o2 o3 vref vdd MFB R1=2.2k R3=680 R2=39k C=1n
XD o3 old vref vdd MFB R1=1.2k R3=1G R2=4.7k C=1n
XN1 in p1 vref vdd MFB R1=2.67k R3=23.7k R2=16.5k C=1n
XN2 p1 p2 vref vdd MFB R1=1.87k R3=16.5k R2=11.8k C=1n
XN3 p2 p3 vref vdd MFB R1=8.45k R3=1.33k R2=52.3k C=1n
XN4 p3 new vref vdd MFB R1=3.92k R3=619 R2=24.3k C=1n
.lib UniversalOpAmp2.lib
.ac list 25k 30k 35k 40k
.meas AC g_old30 FIND mag(V(old)) AT 30k
.meas AC g_new30 FIND mag(V(new)) AT 30k
.options meascplxfmt=cartesian
.meas AC c_old30 FIND V(old) AT 30k
.meas AC c_new30 FIND V(new) AT 30k
.meas AC c_old25 FIND V(old) AT 25k
.meas AC c_new25 FIND V(new) AT 25k
.meas AC c_old40 FIND V(old) AT 40k
.meas AC c_new40 FIND V(new) AT 40k
.end
